# Ansys Electronics Desktop project, version 2025.2
materials:
  Al-Extruded: thermal_conductivity=205 mass_density=2800 specific_heat=900 youngs_modulus=69000000000 poissons_ratio=0.33 thermal_expansion_coefficient=2.277e-06 thermal_material_type=Solid
  air: permittivity=1.0006 permeability=1.0000004 thermal_conductivity=0.0261 mass_density=1.1614 specific_heat=1005 thermal_expansion_coefficient=0.00333 thermal_material_type=Fluid diffusivity=2.88e-05 molecular_mass=0.028966 viscosity=1.84e-05 material_refractive_index=1.000293
  copper: permeability=0.999991 conductivity=58000000 thermal_conductivity=400 mass_density=8933 specific_heat=385 youngs_modulus=120000000000 poissons_ratio=0.38 thermal_expansion_coefficient=1.77e-05
  Silicone Resin-JSME: thermal_conductivity=0.16 mass_density=2200 specific_heat=1300 thermal_material_type=Solid
  silicon: permittivity=11.9 thermal_conductivity=148 mass_density=2330 specific_heat=712 youngs_modulus=135000000000 poissons_ratio=0.25 thermal_expansion_coefficient=2.54e-06
  silver: permeability=0.99998 conductivity=61000000 thermal_conductivity=429 mass_density=10500 specific_heat=235 youngs_modulus=77000000000 poissons_ratio=0.37 thermal_expansion_coefficient=1.89e-05
  PG-25: thermal_conductivity=0.48 mass_density=1016 specific_heat=3970 thermal_expansion_coefficient=0.00039 thermal_material_type=Fluid diffusivity=1.19e-07 molecular_mass=0.0223 viscosity=0.0021
  Silicone: thermal_conductivity=0.2 mass_density=1150 specific_heat=1100
surface materials:
  Steel-oxidised-surface: surface_emissivity=0.8

design IcepakDesign1 (Icepak, SteadyState TemperatureAndFlow, model units mm)
options: Default_Fluid_Material=air Default_Solid_Material=Al-Extruded Default_Surface_Material=Steel-oxidised-surface AmbientTemperature=20cel AmbientPressure=0n_per_meter_sq AmbientRadiationTemperature=20cel Gravity_Vector_CS_ID=Global Gravity_Vector_Axis=Z Positive=false Altitude=0meter OperatingPressure=101325n_per_meter_sq OperatingDensity=1.225kg_per_m3
geometry:
  Region [air] = region(percentage_offset=50 on all sides)
  NONE [copper] = imported_body(C:\Users\altoa\Desktop\Flywheel\model\cad\Assembly_Itherm_2026_Cleanup.STEP)
  NONE_1 [PG-25] = imported_body(C:\Users\altoa\Desktop\Flywheel\model\cad\Assembly_Itherm_2026_Cleanup.STEP)
  NONE_2, NONE_3 [Silicone] = imported_body(C:\Users\altoa\Desktop\Flywheel\model\cad\Assembly_Itherm_2026_Cleanup.STEP)
  NONE_4 = imported_body(C:\Users\altoa\Desktop\Flywheel\model\cad\Assembly_Itherm_2026_Cleanup.STEP)
  NONE_5 [Silicone] = imported_body(C:\Users\altoa\Desktop\Flywheel\model\cad\Assembly_Itherm_2026_Cleanup.STEP)
  NONE_6 = imported_body(C:\Users\altoa\Desktop\Flywheel\model\cad\Assembly_Itherm_2026_Cleanup.STEP)
  NONE_7 [Silicone] = imported_body(C:\Users\altoa\Desktop\Flywheel\model\cad\Assembly_Itherm_2026_Cleanup.STEP)
  NONE_8 [copper] = imported_body(C:\Users\altoa\Desktop\Flywheel\model\cad\Assembly_Itherm_2026_Cleanup.STEP)
  NONE_9 [silicon] = imported_body(C:\Users\altoa\Desktop\Flywheel\model\cad\Assembly_Itherm_2026_Cleanup.STEP)
  group Fin = NONE
  group Fluid = NONE_1
  group Gasket1 = NONE_2
  group Oring_2 = NONE_3
  group manifold = NONE_4
  group Oring_1 = NONE_5
  group TIM = NONE_6
  group Gasket2 = NONE_7
  group baseplate = NONE_8
  group die = NONE_9
mesh:
  Global:  MeshMethod=MesherHD ComputeGap MeshRegionResolution=3 MinGapX=1mm MinGapY=1mm MinGapZ=1mm Objects=Region FacetLevel=3 ProximitySizeFunction CurvatureSizeFunction OptimizePCBMesh
