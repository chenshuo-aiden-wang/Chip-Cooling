# Ansys Electronics Desktop project, version 2025.2
materials:
  Al-Extruded: thermal_conductivity=205 mass_density=2800 specific_heat=900 youngs_modulus=69000000000 poissons_ratio=0.33 thermal_expansion_coefficient=2.277e-06 thermal_material_type=Solid
  air: permittivity=1.0006 permeability=1.0000004 thermal_conductivity=0.0261 mass_density=1.1614 specific_heat=1005 thermal_expansion_coefficient=0.00333 thermal_material_type=Fluid diffusivity=2.88e-05 molecular_mass=0.028966 viscosity=1.84e-05 material_refractive_index=1.000293
surface materials:
  Steel-oxidised-surface: surface_emissivity=0.8

design IcepakDesign1 (Icepak, SteadyState TemperatureAndFlow, model units mm)
options: Default_Fluid_Material=air Default_Solid_Material=Al-Extruded Default_Surface_Material=Steel-oxidised-surface AmbientTemperature=20cel AmbientPressure=0n_per_meter_sq AmbientRadiationTemperature=20cel Gravity_Vector_CS_ID=Global Gravity_Vector_Axis=Z Positive=false Altitude=0meter OperatingPressure=101325n_per_meter_sq OperatingDensity=1.225kg_per_m3
geometry:
  Region [air] = region(percentage_offset=50 on all sides)
  NONE, NONE_1..NONE_8 = imported_body(C:\Users\altoa\Desktop\Flywheel\model\cad\Assembly_Itherm_Cleanup_v.1.0.STEP)
  group part5bodies = NONE
  group part1bodies = NONE_1
  group part6bodies = NONE_2
  group part7bodies = NONE_3
  group part8bodies = NONE_4
  group part4bodies = NONE_5
  group part2bodies = NONE_6
  group part6bodies1 = NONE_7
  group part3bodies = NONE_8
mesh:
  Global:  MeshMethod=MesherHD ComputeGap MeshRegionResolution=3 MinGapX=1mm MinGapY=1mm MinGapZ=1mm Objects=Region FacetLevel=3 ProximitySizeFunction CurvatureSizeFunction OptimizePCBMesh
